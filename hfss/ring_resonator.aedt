# Ansys Electronics Desktop project, version 2025.2
materials:
  vacuum: permittivity=1
  Rogers RO4350 (tm): permittivity=3.66 dielectric_loss_tangent=0.004
  copper: permeability=0.999991 conductivity=58000000
  pec: conductivity=1e+30
  air: permittivity=1.0006 permeability=1.0000004

design HFSSDesign1 (HFSS, HFSS Modal Network, model units mm)
options: Allow_Material_Override
variables:
  BoxW = 10cm
  BoxL = 20cm
  BoxH = 1.524mm
  F0 = 2.4GHz
  Lambda = c0/F0
  Ring_Rad = 13.530765mm
  LineW = 3.4107929mm
  Gap = 0.44561243mm
geometry:
  Box1 [Rogers RO4350 (tm)] = box(corner=(-BoxW/2, -BoxL/2, -BoxH/2), size=(BoxW, BoxL, BoxH))
  Circle1 [copper] = circle(normal=Z, centre=(0mm, 0mm, BoxH/2), radius=Ring_Rad)
  Box1_ObjectFromFace1 [copper] = object_from(Box1.face(-z))
  [Box1_ObjectFromFace1, Circle1].thicken(1copper_oz_per_ft2)
  Circle2 = circle(normal=Z, centre=(0mm, 0mm, BoxH/2), radius=Ring_Rad-LineW)
  Circle2.thicken(1copper_oz_per_ft2)
  Circle1.subtract(Circle2)
  Box2 [copper] = box(corner=(-BoxW/2, -LineW/2, BoxH/2), size=(BoxW/2-Ring_Rad-Gap, LineW, 1copper_oz_per_ft2))
  Box2_1 [copper] = Box2.duplicate_mirror(point=(0mm, 0mm, 0.762mm), normal=(1mm, 0mm, 0mm))
  Box1_ObjectFromFace2 [pec] = object_from(Box1.face(+x))
  Box1_ObjectFromFace2.thicken(2mm)
  Box1_ObjectFromFace2.move_faces(MoveAlongNormalFlag=true OffsetDistance=2cm FacesToMove=Box1_ObjectFromFace2.face(at (51, 0, 0.762)))
  Box1_ObjectFromFace2.move_faces(MoveAlongNormalFlag=true OffsetDistance=-7cm FacesToMove=Box1_ObjectFromFace2.face(at (51, -100, 10), at (51, 100, 10)))
  Box1_ObjectFromFace2_1 [pec] = Box1_ObjectFromFace2.duplicate_mirror(point=(0mm, 0mm, 0.762mm), normal=(-1mm, 0mm, 0mm))
  RadiatingSurface [air] = region(absolute_offset=41.666667mm on all sides)
  Box1.move_faces(MoveAlongNormalFlag=true OffsetDistance=-5cm FacesToMove=Box1.face(+y, -y))
  Box1_ObjectFromFace1.move_faces(MoveAlongNormalFlag=true OffsetDistance=-5cm FacesToMove=Box1_ObjectFromFace1.face(at (0, 100, -0.779029), at (0, -100, -0.779029)))
  group Group1 = Circle1, Box2, Box2_1
boundaries and excitations:
  Open1: Radiation Objects=RadiatingSurface
  1: Wave Port Faces=Box1_ObjectFromFace2.face(at (50, 0, 10)) WavePortType=Modal NumModes=1 Modes{Mode1{CharImp=Zpi}}
  2: Wave Port Faces=Box1_ObjectFromFace2_1.face(at (-50, 0, 10)) WavePortType=Modal NumModes=1 Modes{Mode1{CharImp=Zpi}}
setups:
  Setup1: HfssDriven Frequency=2.4GHz MaxDeltaS=0.02 MaximumPasses=20 MinimumPasses=1 MinimumConvergedPasses=1 PercentRefinement=30 BasisOrder=1 PortAccuracy=2 DrivenSolverType="Direct Solver"
    sweep Sweep: 1.2GHz to 3.6GHz, 401 points; Type=Interpolating InterpTolerance=0.5 InterpMaxSolns=250 InterpUsePortImped=false PassivityErrorTolerance=0.0001
source amplitudes:
  1:1, 2:1: 1W 0deg
radiation setups:
  3D: Infinite Sphere Theta=0deg..180deg step 2deg Phi=-180deg..180deg step 2deg
  Elevation: Infinite Sphere Theta=-180deg..180deg step 1deg Phi=0deg..90deg step 90deg
  Azimuth: Infinite Sphere Theta=90deg..90deg step 0deg Phi=-180deg..180deg step 1deg
reports:
  Port Zo Plot1: re(Zo(1)), im(Zo(1)) vs Freq on Setup1 : Sweep; markers MX1 at x=2.405912e+09
  S Parameter Plot1: dB(S(1,1)), dB(S(2,1)), dB(S(1,2)), dB(S(2,2)) vs Freq on Setup1 : Sweep; markers MX1 at x=2.4e+09

design HFSSDesign2 (HFSS, HFSS Modal Network, model units mm)
options: Allow_Material_Override
variables:
  BoxW = 10cm
  BoxL = 20cm
  BoxH = 1.524mm
  F0 = 2.4GHz
  Lambda = c0/F0
  Ring_Rad = 13.415456mm
  LineW = 3.4082049mm
  Gap = 0.1mm
geometry:
  Box1 [Rogers RO4350 (tm)] = box(corner=(-BoxW/2, -BoxL/2, -BoxH/2), size=(BoxW, BoxL, BoxH))
  Circle1 [copper] = circle(normal=Z, centre=(0mm, 0mm, BoxH/2), radius=Ring_Rad)
  Box1_ObjectFromFace1 [copper] = object_from(Box1.face(-z))
  [Box1_ObjectFromFace1, Circle1].thicken(1copper_oz_per_ft2)
  Circle2 = circle(normal=Z, centre=(0mm, 0mm, BoxH/2), radius=Ring_Rad-LineW)
  Circle2.thicken(1copper_oz_per_ft2)
  Circle1.subtract(Circle2)
  Box2 [copper] = box(corner=(-BoxW/2, -LineW/2, BoxH/2), size=(BoxW/2-Ring_Rad-Gap, LineW, 1copper_oz_per_ft2))
  Box2_1 [copper] = Box2.duplicate_mirror(point=(0mm, 0mm, 0.762mm), normal=(1mm, 0mm, 0mm))
  Box1_ObjectFromFace2 [pec] = object_from(Box1.face(+x))
  Box1_ObjectFromFace2.thicken(2mm)
  Box1_ObjectFromFace2.move_faces(MoveAlongNormalFlag=true OffsetDistance=2cm FacesToMove=Box1_ObjectFromFace2.face(at (51, 0, 0.762)))
  Box1_ObjectFromFace2.move_faces(MoveAlongNormalFlag=true OffsetDistance=-7cm FacesToMove=Box1_ObjectFromFace2.face(at (51, -100, 10), at (51, 100, 10)))
  Box1_ObjectFromFace2_1 [pec] = Box1_ObjectFromFace2.duplicate_mirror(point=(0mm, 0mm, 0.762mm), normal=(-1mm, 0mm, 0mm))
  RadiatingSurface [air] = region(absolute_offset=41.666667mm on all sides)
  Box1.move_faces(MoveAlongNormalFlag=true OffsetDistance=-5cm FacesToMove=Box1.face(+y, -y))
  Box1_ObjectFromFace1.move_faces(MoveAlongNormalFlag=true OffsetDistance=-5cm FacesToMove=Box1_ObjectFromFace1.face(at (0, 100, -0.779029), at (0, -100, -0.779029)))
  group Group1 = Circle1, Box2, Box2_1
boundaries and excitations:
  Open1: Radiation Objects=RadiatingSurface
  1: Wave Port Faces=Box1_ObjectFromFace2.face(at (50, 0, 10)) WavePortType=Modal NumModes=1 Modes{Mode1{CharImp=Zpi}}
  2: Wave Port Faces=Box1_ObjectFromFace2_1.face(at (-50, 0, 10)) WavePortType=Modal NumModes=1 Modes{Mode1{CharImp=Zpi}}
setups:
  Setup1: HfssDriven Frequency=2.4GHz MaxDeltaS=0.02 MaximumPasses=20 MinimumPasses=1 MinimumConvergedPasses=1 PercentRefinement=30 BasisOrder=1 PortAccuracy=2 DrivenSolverType="Direct Solver"
    sweep Sweep: 1.2GHz to 3.6GHz, 401 points; Type=Interpolating InterpTolerance=0.5 InterpMaxSolns=250 InterpUsePortImped=false PassivityErrorTolerance=0.0001
source amplitudes:
  1:1, 2:1: 1W 0deg
radiation setups:
  3D: Infinite Sphere Theta=0deg..180deg step 2deg Phi=-180deg..180deg step 2deg
  Elevation: Infinite Sphere Theta=-180deg..180deg step 1deg Phi=0deg..90deg step 90deg
  Azimuth: Infinite Sphere Theta=90deg..90deg step 0deg Phi=-180deg..180deg step 1deg
reports:
  Port Zo Plot1: re(Zo(1)), im(Zo(1)) vs Freq on Setup1 : Sweep; markers MX1 at x=2.405912e+09
  S Parameter Plot1: dB(S(1,1)), dB(S(2,1)), dB(S(1,2)), dB(S(2,2)) vs Freq on Setup1 : Sweep; markers MX1 at x=2.4e+09
